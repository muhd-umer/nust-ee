** Profile: "SCHEMATIC1-Sim"  [ D:\NUST\SEMESTER 4\ELECTRONIC DEVICES AND CIRCUITS\LABS\Lab 9\lab9-v2-schematic1-sim.sim ]

** Creating circuit file "lab9-v2-schematic1-sim.sim.cir"
** WARNING: THIS AUTOMATICALLY GENERATED FILE MAY BE OVERWRITTEN BY SUBSEQUENT SIMULATIONS

*Libraries:
* Local Libraries :
* From [PSPICE NETLIST] section of C:\Program Files\OrcadLite\PSpice\PSpice.ini file:
.lib "nom.lib"

*Analysis directives:
.TRAN  0 10ms 0 0.00001
.PROBE V(*) I(*) W(*) D(*) NOISE(*)
.INC ".\lab9-v2-SCHEMATIC1.net"

.END
